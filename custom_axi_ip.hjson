{ 
    name: "custom_axi_ip",
    clock_primary: "clk_i",
    reset_primary: "rst_ni",
    bus_interfaces: [
        {
            protocol: "reg_iface", 
            direction: "device"
        }
    ],

    regwidth: "32",
    registers: [
        {
            name: "DIN",
            desc: "Data to be computed",
            swaccess: "wo",
            hwaccess: "hro",
            fields: [
                { bits: "31:0" }
            ]
        },
        {
            name: "DOUT",
            desc: "Result",
            swaccess: "ro",
            hwaccess: "hwo",
            hwext: "true",
            fields: [
                { bits: "31:0" }
            ]
        },
        {
            name: "ENABLE",
            desc: "Enable register",
            swaccess: "wo",
            hwaccess: "hrw",
            fields: [
                { bits: "0" }
            ]
        },
        {
            name: "STATUS",
            desc: "Status register",
            swaccess: "ro",
            hwaccess: "hwo",
            hwext: "true",
            fields: [
                { bits: "1:0",
                  desc: "Current status",
                  enum:[
                    { value: "0", name: "IDLE", desc: "Idle state" },
                    { value: "1", name: "BUSY", desc: "Busy state" },
                    { value: "2", name: "DONE", desc: "Done state" },
                    { value: "3", name: "ERROR", desc: "Error state" }
                  ]
                }
            ]
        }
    ]
}
